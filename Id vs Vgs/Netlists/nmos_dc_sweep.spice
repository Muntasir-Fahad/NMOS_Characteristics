** sch_path: /home/fahad/Desktop/chip/nmos_dc_sweep/nmos_dc_sweep.sch
**.subckt nmos_dc_sweep
XM1 net3 net1 0 0 sky130_fd_pr__nfet_01v8 L=0.15 W=1 nf=1 ad=0.29 as=0.29 pd=2.58 ps=2.58 nrd=0.29 nrs=0.29 sa=0 sb=0 sd=0 mult=1
V1 net1 0 3
V2 net2 0 3
Vmeas net2 net3 0
.save i(vmeas)
**** begin user architecture code

.dc v2 0 1.8 0.01 v1 0 1 0.05
.save all
.end

.lib /usr/local/share/pdk/sky130A/libs.tech/combined/sky130.lib.spice tt
**** end user architecture code
**.ends
.end
